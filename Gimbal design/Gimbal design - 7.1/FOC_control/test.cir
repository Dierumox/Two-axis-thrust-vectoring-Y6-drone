Test INA240

.include INA240A1.lib

VCC VCC 0 5
VREF ref 0 2.5
I_MOTOR in 0 1
RSHUNT in shunt 100m
XINA out shunt 0 ref ref VCC 0 INA240A1

.tran 1u 100u

.end
